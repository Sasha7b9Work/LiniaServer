* D:\1-LTspise\Dradt15_Test\Draft15.asc
XDA1 N009 N001 N003 N010 N011 N015 N016 PA340
R3 N001 N013 4.99k
C1 N015 N016 10p
R8 N002 0 4
R10 N009 N006 4.6k
V5 N013 0 PULSE(0 -0.5 10u 0.1u 0.1u 7u 0.01)
R6 N017 N012 120
XVT1 N003 N004 N005 tip142
XVT2 N010 N017 N014 tip147
R5 N006 N008 1.2k
C2 N006 0 1µ
V6 N008 0 0
R7 N002 N001 40.2k
R9 N004 N007 120
C3 N002 N001 13p
V3 0 N010 55
V1 N003 0 55
R1 N012 N011 500
R2 N002 N005 0.1
R4 N014 N002 0.1
R11 N003 N007 10k
R12 N012 N010 10k
XU1 N012 N007 DI_1N4729A
Q1 N004 P001 N002 0 2N5550
Q2 N017 P002 N002 0 2N5401
R13 N005 P001 300
R14 N014 P002 300
*.model NPN NPN
*.model PNP PNP

.tran 0 60u 0 10n
.options itl4=50
.model 2N5550   NPN(Is=2.511f Xti=3 Eg=1.11 Vaf=100 Bf=213.4 Ne=1.241 Ise=2.511f Ikf=.3495 Xtb=1.5 Br=3.24 Nc=2 Isc=0 Ikr=0 Rc=1 Cjc=4.883p Mjc=.3047 Vjc=.75 Fc=.5 Cje=18.79p Mje=.3416 Vje=.75 Tr=1.212n Tf=560.1p Itf=50m Vtf=5 Xtf=8 Rb=10 Vceo=150 Icrating=600m mfg=Fairchild)
.model 2N5401   PNP(Is=21.48f Xti=3 Eg=1.11 Vaf=100 Bf=132.1 Ne=1.375 Ise=21.48f Ikf=.1848 Xtb=1.5 Br=3.661 Nc=2 Isc=0 Ikr=0 Rc=1.6 Cjc=17.63p  Mjc=.5312 Vjc=.75 Fc=.5 Cje=73.39p Mje=.3777 Vje=.75 Tr=1.476n Tf=641.9p Itf=0 Vtf=0 Xtf=0 Rb=10 Vceo=150 Icrating=600m mfg=Fairchild)
.lib 1N4729A.cir
.lib PA340_Pspice.LIB
.lib TIP142.cir
.lib TIP147.cir
.backanno
.end
