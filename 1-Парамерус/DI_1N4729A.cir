*SRC=1N4729A;DI_1N4729A;Diodes;Zener <=10V; 3.60V  1.00W   Diodes Inc.
Zener
*SYM=HZEN
.SUBCKT DI_1N4729A  1 2
*        Terminals    A   K
D1 1 2 DF
DZ 3 1 DR
VZ 2 3 1.30
.MODEL DF D ( IS=114p RS=0.620 N=1.10
+ CJO=319p VJ=0.750 M=0.330 TT=50.1n )
.MODEL DR D ( IS=22.9f RS=0.923 N=3.00 )
.ENDS
